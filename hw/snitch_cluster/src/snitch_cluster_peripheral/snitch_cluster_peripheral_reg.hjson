// Copyright 2020 ETH Zurich and University of Bologna.
// Solderpad Hardware License, Version 0.51, see LICENSE for details.
// SPDX-License-Identifier: SHL-0.51
// Licensed under Solderpad Hardware License, Version 0.51, see LICENSE for details.
{
    param_list: [
        { name: "NumPerfCounters",
        desc: "Number of performance counters",
        type: "int",
        default: "16"
        },
    ],
    name: "snitch_cluster_peripheral",
    clock_primary: "clk_i",
    bus_interfaces: [
        { protocol: "reg_iface", direction: "device"}
    ]
    regwidth: 64,
    registers: [{
        multireg: {
            name: "PERF_COUNTER_ENABLE",
            desc: "Enable particular performance counter and start tracking.",
            swaccess: "rw",
            hwaccess: "hro",
            count: "NumPerfCounters",
            cname: "performance_counter_enable",
            fields: [{
                bits: "0:0",
                resval: "0",
                name: "CYCLE",
                desc: '''
                    Cycle counter. Counts up as long as the cluster is powered.
                    '''
            },
            {
                bits: "1:1",
                resval: "0",
                name: "TCDM_ACCESSED"
                desc: '''
                        Increased whenever the TCDM is accessed. Each individual access is tracked,
                        so if `n` cores access the TCDM, `n` will be added. Accesses are tracked at the TCDM,
                        so it doesn't matter whether the cores or for example the SSR hardware accesses
                        the TCDM. _This is a cluster-global signal._
                        '''
            },
            {
                bits: "2:2",
                resval: "0",
                name: "TCDM_CONGESTED"
                desc: '''
                        Incremented whenever an access towards the TCDM is made but the arbitration
                        logic didn't grant the access (due to congestion). It's strictly less than TCDM_ACCESSED.
                        _This is a cluster-global signal._
                        '''
            },
            {
                bits: "3:3",
                resval: "0",
                name: "ISSUE_FPU"
                desc: '''
                        Operations performed in the FPU. Includes both operations initiated by the
                        sequencer and by the core. When the Xfrep extension is available, this counter is
                        equivalent to ISSUE_FPU_SEQ (see description of ISSUE_FPU_SEQ). If the Xfrep extension
                        is not supported, then it is equivalent to ISSUE_CORE_TO_FPU. _This is a hart-local signal._
                        '''
            },
            {
                bits: "4:4",
                resval: "0",
                name: "ISSUE_FPU_SEQ"
                desc: '''
                        Incremented whenever the FPU Sequencer issues an FPU instruction.
                        Might not be available if the hardware doesn't support FREP.
                        Note that all FP instructions offloaded by the core to the FPU are routed
                        through the sequencer (although not necessarily buffered) and thus are also counted.
                        The instructions issued independently by the FPU sequencer could thus be
                        calculated as ISSUE_FPU_SEQ_PROPER = ISSUE_FPU_SEQ - ISSUE_CORE_TO_FPU.
                        _This is a hart-local signal._
                        '''
            },
            {
                bits: "5:5",
                resval: "0",
                name: "ISSUE_CORE_TO_FPU"
                desc: '''Incremented whenever the core issues an FPU instruction.
                        _This is a hart-local signal._'''
            },
            {
                bits: "6:6",
                resval: "0",
                name: "RETIRED_INSTR"
                desc: '''
                        Instructions retired by the core, both offloaded and not. Does not
                        count instructions issued independently by the FPU sequencer.
                        _This is a hart-local signal._
                        '''
            },
            {
                bits: "7:7",
                resval: "0",
                name: "RETIRED_LOAD"
                desc: '''
                        Load instructions retired by the core. _This is a hart-local signal._
                        '''
            },
            {
                bits: "8:8",
                resval: "0",
                name: "RETIRED_I"
                desc: '''
                        Base instructions retired by the core. _This is a hart-local signal._
                        '''
            },
            {
                bits: "9:9",
                resval: "0",
                name: "RETIRED_ACC"
                desc: '''
                        Offloaded instructions retired by the core. _This is a hart-local signal._
                        '''
            },
            {
                bits: "10:10",
                resval: "0",
                name: "DMA_AW_STALL"
                desc: '''
                        Incremented whenever aw_valid = 1 but aw_ready = 0.
                        _This is a DMA-local signal_
                        '''
            },
            {
                bits: "11:11",
                resval: "0",
                name: "DMA_AR_STALL"
                desc: '''
                        Incremented whenever ar_valid = 1 but ar_ready = 0.
                        _This is a DMA-local signal_
                        '''
            },
            {
                bits: "12:12",
                resval: "0",
                name: "DMA_R_STALL"
                desc: '''
                        Incremented whenever r_ready = 1 but r_valid = 0.
                        _This is a DMA-local signal_
                        '''
            },
            {
                bits: "13:13",
                resval: "0",
                name: "DMA_W_STALL"
                desc: '''
                        Incremented whenever w_valid = 1 but w_ready = 0.
                        _This is a DMA-local signal_
                        '''
            },
            {
                bits: "14:14",
                resval: "0",
                name: "DMA_BUF_W_STALL"
                desc: '''
                        Incremented whenever w_ready = 1 but w_valid = 0.
                        _This is a DMA-local signal_
                        '''
            },
            {
                bits: "15:15",
                resval: "0",
                name: "DMA_BUF_R_STALL"
                desc: '''
                        Incremented whenever r_valid = 1 but r_ready = 0.
                        _This is a DMA-local signal_
                        '''
            },
            {
                bits: "16:16",
                resval: "0",
                name: "DMA_AW_DONE"
                desc: '''
                        Incremented whenever AW handshake occurs.
                        _This is a DMA-local signal_
                        '''
            },
            {
                bits: "17:17",
                resval: "0",
                name: "DMA_AW_BW"
                desc: '''
                        Whenever AW handshake occurs, the counter is incremented
                        by the number of bytes transfered for this transaction
                        _This is a DMA-local signal_
                        '''
            },
            {
                bits: "18:18",
                resval: "0",
                name: "DMA_AR_DONE"
                desc: '''
                        Incremented whenever AR handshake occurs.
                        _This is a DMA-local signal_
                        '''
            },
            {
                bits: "19:19",
                resval: "0",
                name: "DMA_AR_BW"
                desc: '''
                        Whenever AR handshake occurs, the counter is incremented
                        by the number of bytes transfered for this transaction
                        _This is a DMA-local signal_
                        '''
            },
            {
                bits: "20:20",
                resval: "0",
                name: "DMA_R_DONE"
                desc: '''
                        Incremented whenever R handshake occurs.
                        _This is a DMA-local signal_
                        '''
            },
            {
                bits: "21:21",
                resval: "0",
                name: "DMA_R_BW"
                desc: '''
                        Whenever R handshake occurs, the counter is incremented
                        by the number of bytes transfered in this cycle
                        _This is a DMA-local signal_
                        '''
            },
            {
                bits: "22:22",
                resval: "0",
                name: "DMA_W_DONE"
                desc: '''
                        Incremented whenvever W handshake occurs.
                        _This is a DMA-local signal_
                        '''
            },
            {
                bits: "23:23",
                resval: "0",
                name: "DMA_W_BW"
                desc: '''
                        Whenever W handshake occurs, the counter is incremented
                        by the number of bytes transfered in this cycle
                        _This is a DMA-local signal_
                        '''
            },
            {
                bits: "24:24",
                resval: "0",
                name: "DMA_B_DONE"
                desc: '''
                        Incremented whenever B handshake occurs.
                        _This is a DMA-local signal_
                        '''
            },
            {
                bits: "25:25",
                resval: "0",
                name: "DMA_BUSY"
                desc: '''
                        Incremented whenever DMA is busy.
                        _This is a DMA-local signal_
                        '''
            },
                        {
                bits: "26:26",
                resval: "0",
                name: "ICACHE_MISS"
                desc: '''
                        Incremented for instruction cache misses.
                        _This is a hart-local signal_
                        '''
            },
                        {
                bits: "27:27",
                resval: "0",
                name: "ICACHE_HIT"
                desc: '''
                        Incremented for instruction cache hits.
                        _This is a hart-local signal_
                        '''
            },
                        {
                bits: "28:28",
                resval: "0",
                name: "ICACHE_PREFETCH"
                desc: '''
                        Incremented for instruction cache prefetches.
                        _This is a hart-local signal_
                        '''
            },
                        {
                bits: "29:29",
                resval: "0",
                name: "ICACHE_DOUBLE_HIT"
                desc: '''
                        Incremented for instruction cache double hit.
                        _This is a hart-local signal_
                        '''
            },
                        {
                bits: "30:30",
                resval: "0",
                name: "ICACHE_STALL"
                desc: '''
                        Incremented for instruction cache stalls.
                        _This is a hart-local signal_
                        '''
            },
            ]
        }
    },
    {
        multireg: {
            name: "HART_SELECT",
            desc: '''Select from which hart in the cluster, starting from `0`,
                     the event should be counted. For each performance counter
                     the cores can be selected individually. If a hart greater
                     than the clusters total hart size is selected the selection
                     will wrap and the hart corresponding to `hart_select % total_harts_in_cluster`
                     will be selected.'''
            swaccess: "rw",
            hwaccess: "hro",
            count: "NumPerfCounters",
            cname: "hart_select",
            compact: "false",
            fields: [{
                bits: "9:0",
                name: "HART_SELECT",
                desc: "Select source of per-hart performance counter"
            },
            {
                bits: "19:10",
                name: "PORT_INDEX",
                desc: '''Select which TCDM interconnect input port the `TCDM_PORT_*`
                         events observe. The index space is the interconnect request
                         vector `{soc, cores, snax}`: `0 .. TotalSnaxNarrowTcdmPorts-1`
                         are the SNAX accelerator ports in core order, the next
                         `NrTCDMPortsCores` are the Snitch core data ports, and the
                         last index is the narrow SoC port. Out-of-range values read
                         as no activity.'''
            },
            {
                bits: "23:20",
                name: "PORT_GROUP",
                desc: '''Select which group of TCDM interconnect input ports the
                         `TCDM_GRP_*` events aggregate over. `0` is every port in the
                         cluster, `1 .. NrCores` are the SNAX ports belonging to core
                         `PORT_GROUP-1`, `NrCores+1` is all Snitch core data ports and
                         `NrCores+2` is the narrow SoC port. Out-of-range values read
                         as no activity.'''
            }]
        }
    }
    {
        multireg: {
            name: "PERF_COUNTER",
            desc: '''Performance counter. Set corresponding PERF_COUNTER_ENABLE bits depending on what
            performance metric you would like to track.'''
            swaccess: "rw",
            hwaccess: "hrw",
            count: "NumPerfCounters",
            cname: "performance_counter",
            hwext: "true",
            hwqe: "true",
            fields: [{
                bits: "47:0",
                name: "PERF_COUNTER",
                desc: "Performance counter"
            }]
        }
    },
    {
        name: "CL_CLINT_SET",
        desc: '''
        Set bits in the cluster-local CLINT. Writing a 1 at location i sets the cluster-local interrupt
        of hart i, where i is relative to the first hart in the cluster, ignoring the cluster base hart ID.
        '''
        hwext: "true",
        hwqe: "true",
        swaccess: "wo",
        hwaccess: "hro",
          fields: [{
              bits: "31:0",
              name: "CL_CLINT_SET",
              desc: "Set cluster-local interrupt of hart i"
          }]
    },
    {
        name: "CL_CLINT_CLEAR",
        desc: '''
        Clear bits in the cluster-local CLINT. Writing a 1 at location i clears the cluster-local interrupt
        of hart i, where i is relative to the first hart in the cluster, ignoring the cluster base hart ID.
        '''
        hwext: "true",
        hwqe: "true",
        swaccess: "wo",
        hwaccess: "hro",
          fields: [{
              bits: "31:0",
              name: "CL_CLINT_CLEAR",
              desc: "Clear cluster-local interrupt of hart i"
          }]
    },
    {
        name: "HW_BARRIER",
        desc: '''Hardware barrier register. Loads to this register will block until all cores have
        performed the load. At this stage we know that they reached the same point in the control flow,
        i.e., the cores are synchronized.'''
        swaccess: "ro",
        hwaccess: "hrw",
        hwext: "true",
        fields: [{
            bits: "31:0",
            name: "HW_BARRIER",
            desc: "Hardware barrier register."
        }]
    },
    {
        name: "ICACHE_PREFETCH_ENABLE",
        desc: '''Controls prefetching of the instruction cache.'''
        swaccess: "wo",
        hwaccess: "hro",
        resval: "1",
        fields: [{
            bits: "0:0",
            name: "ICACHE_PREFETCH_ENABLE",
            desc: "Enable instruction prefetching."
        }]
    },
    {
        multireg: {
            name: "PERF_COUNTER_ENABLE_EXT",
            desc: '''Extended performance counter event select. This is the
                     continuation of `PERF_COUNTER_ENABLE` for events that did not fit
                     in its lower 32 bits, which is the widest single store an RV32
                     hart can issue. A counter observes the first enabled event found
                     scanning `PERF_COUNTER_ENABLE` and then `PERF_COUNTER_ENABLE_EXT`,
                     so software must leave `PERF_COUNTER_ENABLE` clear when selecting
                     an event from this register.''',
            swaccess: "rw",
            hwaccess: "hro",
            count: "NumPerfCounters",
            cname: "performance_counter_enable_ext",
            fields: [{
                bits: "0:0",
                resval: "0",
                name: "TCDM_GRP_REQ"
                desc: '''
                        Incremented every cycle by the number of TCDM interconnect input
                        ports in the group selected by `PORT_GROUP` that presented a
                        request, granted or not. This is the offered load of one engine.
                        _This is a cluster-global signal._
                        '''
            },
            {
                bits: "1:1",
                resval: "0",
                name: "TCDM_GRP_STALL"
                desc: '''
                        Incremented every cycle by the number of TCDM interconnect input
                        ports in the group selected by `PORT_GROUP` that presented a
                        request which was not granted. Granted requests are
                        `TCDM_GRP_REQ - TCDM_GRP_STALL`; at 8 byte per narrow port that
                        is the group's achieved TCDM bandwidth.
                        _This is a cluster-global signal._
                        '''
            },
            {
                bits: "2:2",
                resval: "0",
                name: "TCDM_PORT_REQ"
                desc: '''
                        Incremented whenever the single TCDM interconnect input port
                        selected by `PORT_INDEX` presents a request. Use this to break a
                        group down channel by channel.
                        _This is a cluster-global signal._
                        '''
            },
            {
                bits: "3:3",
                resval: "0",
                name: "TCDM_PORT_STALL"
                desc: '''
                        Incremented whenever the single TCDM interconnect input port
                        selected by `PORT_INDEX` presents a request that is not granted.
                        _This is a cluster-global signal._
                        '''
            },
            {
                bits: "4:4",
                resval: "0",
                name: "TCDM_BANK_SERVED"
                desc: '''
                        Incremented every cycle by the number of TCDM banks that accepted
                        a narrow request. Divided by `CYCLE * NrBanks` this is the narrow
                        bank utilisation, the ceiling every engine is competing for.
                        _This is a cluster-global signal._
                        '''
            },
            {
                bits: "5:5",
                resval: "0",
                name: "TCDM_WIDE_PREEMPT"
                desc: '''
                        Incremented every cycle by the number of TCDM banks that had a
                        narrow request pending while their super bank was handed to the
                        wide DMA port, which wins unconditionally. This is the bank-cycle
                        cost the DMA imposes on everything else, and it is invisible in
                        the DMA's own counters.
                        _This is a cluster-global signal._
                        '''
            },
            {
                bits: "6:6",
                resval: "0",
                name: "TCDM_WIDE_REQ"
                desc: '''
                        Incremented whenever the wide DMA port completes a TCDM access.
                        Multiply by `WideDataWidth/8` for bytes moved into or out of the
                        TCDM by the DMA.
                        _This is a cluster-global signal._
                        '''
            },
            {
                bits: "7:7",
                resval: "0",
                name: "TCDM_WIDE_STALL"
                desc: '''
                        Incremented whenever the wide DMA port presents a TCDM access that
                        is not granted. The wide port has priority over the narrow
                        interconnect, so this only counts atomic-unit conflicts.
                        _This is a cluster-global signal._
                        '''
            },
            {
                bits: "8:8",
                resval: "0",
                name: "ICACHE_L1_MISS"
                desc: '''
                        Incremented for shared L1 instruction cache misses, summed over
                        hives. Unlike `ICACHE_MISS`, which is the hart-private L0 buffer,
                        this is the refill traffic that actually reaches the AXI port.

                        THIS IS THE EVENT THAT COSTS CYCLES, and the cost is not any of
                        the counters here: multiply it by the refill latency, which on a
                        target whose `.text` lives in main memory is a full AXI round
                        trip. `ICACHE_L1_STALL` does NOT measure it -- see there.
                        _This is a cluster-global signal._
                        '''
            },
            {
                bits: "9:9",
                resval: "0",
                name: "ICACHE_L1_HIT"
                desc: '''
                        Incremented for shared L1 instruction cache hits, summed over
                        hives. _This is a cluster-global signal._
                        '''
            },
            {
                bits: "10:10",
                resval: "0",
                name: "ICACHE_L1_STALL"
                desc: '''
                        Incremented whenever the shared L1 instruction cache stalls a
                        lookup, summed over hives. With several harts fetching from one
                        cache this is where they contend with each other.

                        NOT THE CORE'S FETCH STALL. The RTL defines this as the lookup
                        stage's own backpressure (`in_valid_i & ~in_ready_o`), so it stays
                        small even when cores are waiting hundreds of cycles for refills.
                        No field of `icache_l1_events_t` measures that wait; use
                        `ICACHE_L1_MISS` times the refill latency, or read it off an
                        instruction trace.
                        _This is a cluster-global signal._
                        '''
            },
            {
                bits: "11:11",
                resval: "0",
                name: "ICACHE_L1_HANDLER_STALL"
                desc: '''
                        Incremented whenever the shared L1 instruction cache refill
                        handler stalls, summed over hives. A large value next to a small
                        `ICACHE_L1_MISS` means the misses are serialising on one handler.
                        _This is a cluster-global signal._
                        '''
            },
            ]
        }
    }
    ]
}
